//Verilog-AMS HDL for "BAM_V1", "Weight_Row" "verilogams"

`include "constants.vams"
`include "disciplines.vams"
`define Rcol 24
module Weight_Row (Col_Vec,Row,Enx,Eny,X,Y,Lu_clk);
inout [`Rcol:1]Col_Vec;
input [`Rcol:1]Eny;
input [`Rcol:1]Y;
inout Row;
input Enx,X,Lu_clk;

electrical Row,Enx,X,Lu_clk;
electrical [`Rcol:1]Col_vec;
electrical [`Rcol:1]Eny;
electrical [`Rcol:1]Y;
electrical [`Rcol:1]op;
genvar i;
generate
for(i=1;i<`Rcol+1;i=i+1)
   begin: Column
   Weight_SinglePlus I_mr_weight(
					 .P    	(op[i]),
					 .N		(Row)
					 );
   LU I_lu_1(
					 .Lclk		(Lu_clk),
					 .X			(X),
					 .Y			(Y[i]),
					 .Enx		(Enx),
					 .Eny		(Eny[i]),
					 .Outp		(op[i]),
				     .Outn		(Row),
				     .IO_S		(Col_Vec[i])
					 );
    end
endgenerate
endmodule
