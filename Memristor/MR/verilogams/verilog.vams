//Verilog-AMS HDL for "Memristor", "MR" "verilogams"

`include "constants.vams"
`include "disciplines.vams"

module MR (P,N );
inout P,N;
 electrical P,N;
 parameter real ud =1e-12;
 parameter real D = 10e-9;
 parameter real Ron = 100;
 parameter real Roff = 16000;
 parameter real Wo = 5e-9;
 parameter real p_drift = 10;

 real vd,W,M,f_drift;
//////////////////////////////////
 analog function real stp;
 input i;
 real i;
 begin
 stp=(i >= 0) ? 1:0;
 end
 endfunction
/////////////////////////////////
 analog begin
 vd = ud*Ron*I(P,N)*f_drift/D;
 W = idt(vd,Wo);
 if (W<0) W=0;
 else if (W>D) W=D;
 M = (Ron*(W/D))+(Roff*(1-W/D));
 V(P,N) <+ I(P,N)*M;

 f_drift = 1-pow((W/D)-stp(-I(P,N)),(2*p_drift));
 end
endmodule
