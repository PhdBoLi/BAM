//Verilog-AMS HDL for "BAM_V1", "Weight_Single" "verilogams"

`include "constants.vams"
`include "disciplines.vams"

module Weight_SinglePlus (P, N);
inout P,N;
electrical P,N;
real  w0;

memristor
//          #(
//		   .Wo	    ()
//		   )
           M1(
			.P		(P),
			.N		(N)
			);

endmodule
